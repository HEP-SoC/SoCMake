addrmap simple{
    reg {
        field {} f1[32];
    } r1;
};
